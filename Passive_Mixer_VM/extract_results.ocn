openResults( "./psf" )
results()
v_out_mag = mag(harmonic(v("VO_IP" ?result "pac") -1)-harmonic(v("VO_IN" ?result "pac") -1) )
gain_db = db20(v_out_mag)
awvSaveToCSV(gain_db "gain.csv")
s11 = getData("s11" ?result "psp")
s11_db = db20(s11)
awvSaveToCSV(s11_db "s11.csv")
selectResult("pnoise")
output_noise_power = pow(getData("out") 2)
integ_NFactor_numerator = integ(output_noise_power 1K 10M)
output_noise_power_divided_NFactor = pow(getData("out") 2)/pow(10 getData("NF")/10)
integ_NFactor_denominator = integ(output_noise_power_divided_NFactor 1K 10M)
integ_NF_db = 10*log10(integ_NFactor_numerator/integ_NFactor_denominator)
awvSaveToCSV(integ_NF_db "NF.csv")
idd = mag( harmonic( rms( i("V0:p" ?result "pss_fd") ) 0 ) )
awvSaveToCSV(idd "idd.csv")
exit
