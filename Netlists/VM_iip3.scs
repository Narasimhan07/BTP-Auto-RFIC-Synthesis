// Design: Passive_mixer_ee20b087/Mixer_SB_VM_25D_TB_tsmc
simulator lang=spectre
global 0
parameters cap_w=17.549410518
parameters flo=100000000.0
parameters frf1=101000000.0
parameters frf2=101100000.0
parameters prf=-10
parameters prf_min=-30
parameters prf_max=-5
parameters prf_step=0.5
parameters res_w=35.1317291919
parameters sw_fin=19
parameters sw_mul=2
parameters w_per_fin=1.01247660208e-06
parameters temperature=27
include "/cad/library/TSMC/65/lp/tsmcN65/../models/spectre/toplevel.scs" section=tt_lib

// Passive_mixer_ee20b087/RC_tank/schematic
subckt RC_tank in
parameters _par0=10 _par1=10
R0 (in 0 0) rppolyl_rf l=_par0*1u w=2u m=1 mismatchflag=0
C4 (in 0 0) mimcap_um_sin_rf lt=_par1*4u wt=_par1*4u m=1 mimflag=3 mismatchflag=0
C3 (in 0 0) mimcap_um_sin_rf lt=_par1*4u wt=_par1*4u m=1 mimflag=3 mismatchflag=0
C2 (in 0 0) mimcap_um_sin_rf lt=_par1*4u wt=_par1*4u m=1 mimflag=3 mismatchflag=0
C1 (in 0 0) mimcap_um_sin_rf lt=_par1*4u wt=_par1*4u m=1 mimflag=3 mismatchflag=0
C0 (in 0 0) mimcap_um_sin_rf lt=_par1*4u wt=_par1*4u m=1 mimflag=3 mismatchflag=0
ends RC_tank

// Passive_mixer_ee20b087/voltage_mode_SB_25D_tsmc/schematic
subckt voltage_mode_SB_25D_tsmc LO\+ LO\- VO_N VO_P V_RF
I0 (VO_P) RC_tank _par0=res_w _par1=cap_w
I1 (VO_N) RC_tank _par0=res_w _par1=cap_w
M0 (V_RF LO\+ VO_P 0) nmos_rf lr=60n wr=w_per_fin nr=sw_fin m=sw_mul sigma=1
M1 (V_RF LO\- VO_N 0) nmos_rf lr=60n wr=w_per_fin nr=sw_fin m=sw_mul sigma=1
ends voltage_mode_SB_25D_tsmc

// Passive_mixer_ee20b087/Mixer_SB_VM_25D_TB_tsmc/schematic
E5 (net021 0 VO_IN 0) vcvs gain=1.0
E4 (net022 0 VO_IP 0) vcvs gain=1.0
E3 (\270D_OUT 0 net011 0) vcvs gain=1.0
E2 (\90D_OUT 0 net07 0) vcvs gain=1.0
E1 (\180D_OUT 0 net012 0) vcvs gain=1.0
E0 (\0D_OUT 0 net08 0) vcvs gain=1.0
I1 (\90D_OUT \270D_OUT VO_QN VO_QP net9) voltage_mode_SB_25D_tsmc
I0 (\0D_OUT \180D_OUT VO_IN VO_IP net9) voltage_mode_SB_25D_tsmc
PORT0 (net9 0) port r=50 type=sine freq=frf1 dbm=prf freq2=frf2 dbm2=prf pacmag=1 fundname="frf1" fundname2="frf2"
PORT4 (net011 0) port r=50 type=pulse delay=0.75*(1/flo) val0=0 val1=1.2 period=1/flo rise=0.001*(1/flo) fall=0.001*(1/flo) width=0.25*(1/flo) fundname="LO_270"
PORT3 (net07 0) port r=50 type=pulse delay=0.25*(1/flo) val0=0 val1=1.2 period=1/flo rise=0.001*(1/flo) fall=0.001*(1/flo) width=0.25*(1/flo) fundname="LO_90"
PORT2 (net012 0) port r=50 type=pulse delay=0.5*(1/flo) val0=0 val1=1.2 period=1/flo rise=0.001*(1/flo) fall=0.001*(1/flo) width=0.25*(1/flo) fundname="LO_180"
PORT1 (net08 0) port r=50 type=pulse delay=0 val0=0 val1=1.2 period=1/flo rise=0.001*(1/flo) fall=0.001*(1/flo) width=0.25*(1/flo) fundname="LO_0"
R3 (net07 0) resistor r=50
R2 (net011 0) resistor r=50
R0 (net08 0) resistor r=50
R1 (net012 0) resistor r=50
PORT5 (net022 net021) port r=50 type=dc
simulatorOptions options temp=27
// ANALYSIS STATEMENTS
sweephb sweep param=prf start=prf_min stop=prf_max step=prf_step {
hb_test hb autotstab=yes oversample=[1 1 1] fundfreqs=[(flo) (frf1)
+ (frf2)] maxharms=[30 3 3] errpreset=conservative annotate=status

}
