// Design: Narasimhan/Mixer_SB_CM_25D_TB
simulator lang=spectre
global 0
parameters CL=10p
parameters RL=1K
parameters w_per_fin=1u
parameters gm=2
parameters RN=100
parameters flo=500M
parameters frf1=501M
parameters frf2=501.1M
parameters prf=-10
parameters prf_min=-40
parameters prf_max=-5
parameters prf_step=2
parameters G=100
parameters sw_fin=30
parameters sw_mul=2
parameters temperature=27
include "/cad/library/TSMC/65/lp/tsmcN65/../models/spectre/toplevel.scs" section=tt_lib

// Narasimhan/transimpedance_amplifier/schematic
subckt transimpedance_amplifier In Out
parameters _par0=100 _par1=1K _par2=10p
    E0 (Out 0 0 In) vcvs gain=_par0
    R0 (In Out) resistor r=_par1
    C0 (In Out) capacitor c=_par2
ends transimpedance_amplifier

// Narasimhan/current_mode_25D_mixer/schematic
subckt current_mode_25D_mixer IF_N IF_P LO\+ LO\- RF
    M1 (RF LO\- net4 0) nmos_rf lr=60n wr=w_per_fin nr=sw_fin m=sw_mul sigma=1
    M0 (RF LO\+ net8 0) nmos_rf lr=60n wr=w_per_fin nr=sw_fin m=sw_mul sigma=1
    I1 (net4 IF_N) transimpedance_amplifier _par0=G _par1=RL _par2=CL
    I0 (net8 IF_P) transimpedance_amplifier _par0=G _par1=RL _par2=CL
ends current_mode_25D_mixer

// Narasimhan/Mixer_SB_CM_25D_TB/schematic
I1 (VO_QN VO_QP LO_90 LO_270 net07) current_mode_25D_mixer
I0 (VO_IN VO_IP LO_0 LO_180 net07) current_mode_25D_mixer
PORT6 (net026 net025) port r=50 type=dc
PORT5 (net027 net028) port r=50 type=dc
R10 (net07 0) resistor r=RN
R5 (net019 0) resistor r=50
R3 (net16 0) resistor r=50
R2 (net10 0) resistor r=50
R1 (net17 0) resistor r=50
R0 (net11 0) resistor r=50
PORT4 (net16 0) port r=50 type=pulse delay=0.75*(1/flo) val0=0 val1=1.2 period=1/flo rise=0.001*(1/flo) fall=0.001*(1/flo) width=0.25*(1/flo) fundname="LO_270"
PORT2 (net17 0) port r=50 type=pulse delay=0.25*(1/flo) val0=0 val1=1.2 period=1/flo rise=0.001*(1/flo) fall=0.001*(1/flo) width=0.25*(1/flo) fundname="LO_90"
PORT3 (net10 0) port r=50 type=pulse delay=0.5*(1/flo) val0=0 val1=1.2 period=1/flo rise=0.001*(1/flo) fall=0.001*(1/flo) width=0.25*(1/flo) fundname="LO_180"
PORT1 (net11 0) port r=50 type=pulse delay=0 val0=0 val1=1.2 period=1/flo rise=0.001*(1/flo) fall=0.001*(1/flo) width=0.25*(1/flo) fundname="LO_0"
E7 (net025 0 VO_QN 0) vcvs gain=1.0
E4 (net028 0 VO_IN 0) vcvs gain=1.0
E5 (net027 0 VO_IP 0) vcvs gain=1.0
E6 (net026 0 VO_QP 0) vcvs gain=1.0
E0 (LO_0 0 net11 0) vcvs gain=1.0
E1 (LO_180 0 net10 0) vcvs gain=1.0
E3 (LO_270 0 net16 0) vcvs gain=1.0
E2 (LO_90 0 net17 0) vcvs gain=1.0
PORT0 (net019 0) port r=50 type=sine freq=frf1 dbm=prf freq2=frf2 dbm2=prf pacmag=1 fundname="frf1" fundname2="frf2"
G0 (net07 0 net019 0) vccs gm=gm
simulatorOptions options temp=temperature
// ANALYSIS STATEMENTS
sweephb sweep param=prf start=prf_min stop=prf_max step=prf_step {
hb_test hb autotstab=yes oversample=[1 1 1] fundfreqs=[(flo) (frf1)
+ (frf2)] maxharms=[30 4 4] errpreset=conservative annotate=status

}
