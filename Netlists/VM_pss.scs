// Design: Passive_mixer_ee20b087/Mixer_SB_VM_25D_TB_tsmc_with_buffer
simulator lang=spectre
global 0
// PARAMETERS
parameters cap_w=14.493
parameters res_w=50.78
parameters sw_mul=97
parameters Vdd=1.2
parameters sw_wn=1.0088u
parameters wp0=3.17u
parameters wp1=2.4303u
parameters wp2=2.09616u
parameters wp3=2.0299u
parameters wn0=1u
parameters wn1=1.149999u
parameters wn2=1.0579999u
parameters wn3=1.013916u
parameters mp0=1
parameters mp1=3
parameters mp2=8
parameters mp3=19
parameters mn0=1
parameters mn1=2
parameters mn2=5
parameters mn3=12
parameters flo=100000000.0
parameters flo_start=100000000.0
parameters flo_stop=1000000000.0
parameters Bandwidth=10000000.0
parameters res_w=50.785377608994885
parameters sw_wn=1.0088071220436986e-06
parameters sw_mul=97.0
parameters temperature=27
include "/cad/library/TSMC/65/lp/tsmcN65/../models/spectre/toplevel.scs" section=tt_lib

// Passive_mixer_ee20b087/RC_tank/schematic
subckt RC_tank in
parameters _par0=10 _par1=10
R0 (in 0 0) rppolyl_rf l=_par0*1u w=2u m=1 mismatchflag=0
C4 (in 0 0) mimcap_um_sin_rf lt=_par1*4u wt=_par1*4u m=1 mimflag=3 mismatchflag=0
C3 (in 0 0) mimcap_um_sin_rf lt=_par1*4u wt=_par1*4u m=1 mimflag=3 mismatchflag=0
C2 (in 0 0) mimcap_um_sin_rf lt=_par1*4u wt=_par1*4u m=1 mimflag=3 mismatchflag=0
C1 (in 0 0) mimcap_um_sin_rf lt=_par1*4u wt=_par1*4u m=1 mimflag=3 mismatchflag=0
C0 (in 0 0) mimcap_um_sin_rf lt=_par1*4u wt=_par1*4u m=1 mimflag=3 mismatchflag=0
ends RC_tank

// Passive_mixer_ee20b087/voltage_mode_DB_fd_25D/schematic
subckt voltage_mode_DB_fd_25D I\+ I\- IN\+ IN\- LO_0 LO_180 LO_270 LO_90 Q\+ Q\-
    M7 (IN\- LO_90 Q\- 0) nmos_rf lr=60n wr=sw_wn nr=1 m=sw_mul sigma=1
    M6 (IN\+ LO_270 Q\- 0) nmos_rf lr=60n wr=sw_wn nr=1 m=sw_mul sigma=1
    M4 (IN\+ LO_90 Q\+ 0) nmos_rf lr=60n wr=sw_wn nr=1 m=sw_mul sigma=1
    M5 (IN\- LO_270 Q\+ 0) nmos_rf lr=60n wr=sw_wn nr=1 m=sw_mul sigma=1
    M3 (IN\- LO_0 I\- 0) nmos_rf lr=60n wr=sw_wn nr=1 m=sw_mul sigma=1
    M2 (IN\+ LO_180 I\- 0) nmos_rf lr=60n wr=sw_wn nr=1 m=sw_mul sigma=1
    M1 (IN\- LO_180 I\+ 0) nmos_rf lr=60n wr=sw_wn nr=1 m=sw_mul sigma=1
    M0 (IN\+ LO_0 I\+ 0) nmos_rf lr=60n wr=sw_wn nr=1 m=sw_mul sigma=1
    RC3 (Q\-) RC_tank _par0=cap_w _par1=res_w
    RC2 (Q\+) RC_tank _par0=cap_w _par1=res_w
    RC1 (I\-) RC_tank _par0=cap_w _par1=res_w
    RC0 (I\+) RC_tank _par0=cap_w _par1=res_w
ends voltage_mode_DB_fd_25D

// Passive_mixer_ee20b087/Inverter/schematic
subckt Inverter VDD Vin Vout
parameters wn=1u muln=1 wp=2u mulp=1
    M0 (Vout Vin 0 0) nmos_rf lr=60n wr=wn nr=1 m=muln sigma=1
    M1 (Vout Vin VDD VDD) pmos_rf lr=60n wr=wp nr=1 m=mulp sigma=1
ends Inverter

// Passive_mixer_ee20b087/buffer_block/schematic
subckt buffer_block In Out Vdd
I3 (Vdd w2 Out) Inverter wn=wn3 muln=mn3 wp=wp3 mulp=mp3
I2 (Vdd w1 w2) Inverter wn=wn2 muln=mn2 wp=wp2 mulp=mp2
I1 (Vdd w0 w1) Inverter wn=wn1 muln=mn1 wp=wp1 mulp=mp1
I0 (Vdd In w0) Inverter wn=wn0 muln=mn0 wp=wp0 mulp=mp0
ends buffer_block

// Passive_mixer_ee20b087/Mixer_DB_VM_25D_TB_tsmc/schematic
E7 (net020 0 VO_QN 0) vcvs gain=1.0
E6 (net026 0 VO_QP 0) vcvs gain=1.0
E5 (net025 0 VO_IN 0) vcvs gain=1.0
E4 (net033 0 VO_IP 0) vcvs gain=1.0
E3 (\270D_OUT 0 net011 0) vcvs gain=1.0
E2 (\90D_OUT 0 net07 0) vcvs gain=1.0
E1 (\180D_OUT 0 net012 0) vcvs gain=1.0
E0 (\0D_OUT 0 net08 0) vcvs gain=1.0
V0 (Vdd 0) vsource dc=Vdd type=dc
I0 (net018 IN_P IN_N) balun rin=50 rout=50 loss=0
I1 (VO_IP VO_IN IN_P IN_N net032 net014 net031 net013 VO_QP VO_QN) voltage_mode_DB_fd_25D
PORT4 (net011 0) port r=50 type=pulse delay=0.75*(1/flo) val0=0 val1=1.2 period=1/flo rise=0.001*(1/flo) fall=0.001*(1/flo) width=0.25*(1/flo) fundname="LO_270"
PORT3 (net07 0) port r=50 type=pulse delay=0.25*(1/flo) val0=0 val1=1.2 period=1/flo rise=0.001*(1/flo) fall=0.001*(1/flo) width=0.25*(1/flo) fundname="LO_90"
PORT2 (net012 0) port r=50 type=pulse delay=0.5*(1/flo) val0=0 val1=1.2 period=1/flo rise=0.001*(1/flo) fall=0.001*(1/flo) width=0.25*(1/flo) fundname="LO_180"
PORT1 (net08 0) port r=50 type=pulse delay=0 val0=0 val1=1.2 period=1/flo rise=0.001*(1/flo) fall=0.001*(1/flo) width=0.25*(1/flo) fundname="LO_0"
B0 (\0D_OUT net032 Vdd) buffer_block
B1 (\90D_OUT net013 Vdd) buffer_block
B3 (\270D_OUT net031 Vdd) buffer_block
B2 (\180D_OUT net014 Vdd) buffer_block
R3 (net07 0) resistor r=50
R2 (net011 0) resistor r=50
R0 (net08 0) resistor r=50
R1 (net012 0) resistor r=50
PORT6 (net026 net020) port r=50 type=dc
PORT5 (net033 net025) port r=50 type=dc
PORT0 (net018 0) port r=50 type=dc pacmag=1
simulatorOptions options temp=temperature
// ANALYSIS STATEMENTS
sweeppss sweep param=flo start=flo_start stop=flo_stop lin=2 {
pss_test pss fund=flo harms=50 errpreset=conservative restart=yes
+ annotate=status
// PAC STATEMENTS
pac_test pac sweeptype=absolute start=flo+Bandwidth maxsideband=10
+ annotate=status
pnoise_test ( VO_IP VO_IN ) pnoise sweeptype=absolute
+ start=1K stop=Bandwidth lin=100 maxsideband=10 iprobe=PORT0
+ refsideband=-1 noiseout=[usb] annotate=status
// PSP STATEMENTS
psp_test psp sweeptype=absolute start=flo portharmsvec=[1]
+ ports=[PORT0] annotate=status datatype=dbphase
}

save V0:p
ahdl_include "/cad/tools/cadencetools/IC618/tools/dfII/samples/artist/rfLib/balun/veriloga/veriloga.va"
