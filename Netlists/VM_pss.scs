// Design: Passive_mixer_ee20b087/Mixer_SB_VM_25D_TB_tsmc
simulator lang=spectre
global 0
parameters cap_w=14.493566415833614
parameters flo=100000000.0
parameters flo_start=100000000.0
parameters flo_stop=1000000000.0
parameters Bandwidth=10000000.0
parameters res_w=50.785377608994885
parameters sw_wn=1.0088071220436986e-06
parameters sw_mul=97.0
parameters temperature=27
include "/cad/library/TSMC/65/lp/tsmcN65/../models/spectre/toplevel.scs" section=tt_lib

// Passive_mixer_ee20b087/RC_tank/schematic
subckt RC_tank in
parameters _par0=10 _par1=10
R0 (in 0 0) rppolyl_rf l=_par0*1u w=2u m=1 mismatchflag=0
C4 (in 0 0) mimcap_um_sin_rf lt=_par1*4u wt=_par1*4u m=1 mimflag=3 mismatchflag=0
C3 (in 0 0) mimcap_um_sin_rf lt=_par1*4u wt=_par1*4u m=1 mimflag=3 mismatchflag=0
C2 (in 0 0) mimcap_um_sin_rf lt=_par1*4u wt=_par1*4u m=1 mimflag=3 mismatchflag=0
C1 (in 0 0) mimcap_um_sin_rf lt=_par1*4u wt=_par1*4u m=1 mimflag=3 mismatchflag=0
C0 (in 0 0) mimcap_um_sin_rf lt=_par1*4u wt=_par1*4u m=1 mimflag=3 mismatchflag=0
ends RC_tank

// Passive_mixer_ee20b087/voltage_mode_SB_25D_tsmc/schematic
subckt voltage_mode_SB_25D_tsmc LO\+ LO\- VO_N VO_P V_RF
I0 (VO_P) RC_tank _par0=res_w _par1=cap_w
I1 (VO_N) RC_tank _par0=res_w _par1=cap_w
M0 (V_RF LO\+ VO_P 0) nmos_rf lr=60n wr=sw_wn nr=1 m=sw_mul sigma=1
M1 (V_RF LO\- VO_N 0) nmos_rf lr=60n wr=sw_wn nr=1 m=sw_mul sigma=1
ends voltage_mode_SB_25D_tsmc

// Passive_mixer_ee20b087/Mixer_SB_VM_25D_TB_tsmc/schematic
E4 (net022 0 VO_IP 0) vcvs gain=1.0
E3 (\270D_OUT 0 net011 0) vcvs gain=1.0
E2 (\90D_OUT 0 net07 0) vcvs gain=1.0
E1 (\180D_OUT 0 net012 0) vcvs gain=1.0
E0 (\0D_OUT 0 net08 0) vcvs gain=1.0
E5 (net021 0 VO_IN 0) vcvs gain=1.0
I0 (\0D_OUT \180D_OUT VO_IN VO_IP net9) voltage_mode_SB_25D_tsmc
I1 (\90D_OUT \270D_OUT VO_QN VO_QP net9) voltage_mode_SB_25D_tsmc
PORT4 (net011 0) port r=50 type=pulse delay=0.75*(1/flo) val0=0 val1=1.2 period=1/flo rise=0.001*(1/flo) fall=0.001*(1/flo) width=0.25*(1/flo) fundname="LO_270"
PORT3 (net07 0) port r=50 type=pulse delay=0.25*(1/flo) val0=0 val1=1.2 period=1/flo rise=0.001*(1/flo) fall=0.001*(1/flo) width=0.25*(1/flo) fundname="LO_90"
PORT2 (net012 0) port r=50 type=pulse delay=0.5*(1/flo) val0=0 val1=1.2 period=1/flo rise=0.001*(1/flo) fall=0.001*(1/flo) width=0.25*(1/flo) fundname="LO_180"
PORT1 (net08 0) port r=50 type=pulse delay=0 val0=0 val1=1.2 period=1/flo rise=0.001*(1/flo) fall=0.001*(1/flo) width=0.25*(1/flo) fundname="LO_0"
R3 (net07 0) resistor r=50
R2 (net011 0) resistor r=50
R0 (net08 0) resistor r=50
R1 (net012 0) resistor r=50
PORT5 (net022 net021) port r=50 type=dc
PORT0 (net9 0) port r=50 type=dc pacmag=1
simulatorOptions options temp=temperature
// ANALYSIS STATEMENTS
sweeppss sweep param=flo start=flo_start stop=flo_stop lin=2 {
pss_test pss fund=flo harms=50 errpreset=conservative restart=yes
+ annotate=status
// PAC STATEMENTS
pac_test pac sweeptype=absolute start=flo+Bandwidth maxsideband=10
+ annotate=status
pnoise_test ( VO_IP VO_IN ) pnoise sweeptype=absolute
+ start=1K stop=Bandwidth lin=100 maxsideband=10 iprobe=PORT0
+ refsideband=-1 noiseout=[usb] annotate=status
// PSP STATEMENTS
psp_test psp sweeptype=absolute start=flo portharmsvec=[1]
+ ports=[PORT0] annotate=status datatype=dbphase
}
