// Design: Narasimhan/Mixer_SB_CM_25D_TB_tsmc
simulator lang=spectre
global 0
// PARAMETERS
parameters cap_w=10
parameters res_w=75
parameters gm=20m
parameters RN=250
parameters G=100
parameters sw_mul=75
parameters flo=500M
parameters flo_start=100M
parameters flo_stop=1G
parameters Bandwidth=10M
parameters temperature=27
include "/cad/library/TSMC/65/lp/tsmcN65/../models/spectre/toplevel.scs" section=tt_lib

// Narasimhan/transimpedance_amplifier_tsmc/schematic
subckt transimpedance_amplifier_tsmc In Out
parameters _par0=100 _par1=100 _par2=20
    E0 (Out 0 0 In) vcvs gain=_par0 type=vcvs
    R4 (Out net09 0) rppolyl_rf l=_par1*1u w=2u m=1 mismatchflag=0
    R3 (net09 net08 0) rppolyl_rf l=_par1*1u w=2u m=1 mismatchflag=0
    R2 (net10 net08 0) rppolyl_rf l=_par1*1u w=2u m=1 mismatchflag=0
    R0 (In net11 0) rppolyl_rf l=_par1*1u w=2u m=1 mismatchflag=0
    R1 (net11 net10 0) rppolyl_rf l=_par1*1u w=2u m=1 mismatchflag=0
    C2 (In Out) mimcap_sin lt=_par2*2u wt=_par2*2u mimflag=3 mf=1 mismatchflag=0
    C1 (In Out) mimcap_sin lt=_par2*2u wt=_par2*2u mimflag=3 mf=1 mismatchflag=0
    C0 (In Out) mimcap_sin lt=_par2*2u wt=_par2*2u mimflag=3 mf=1 mismatchflag=0
ends transimpedance_amplifier_tsmc

// Narasimhan/current_mode_DB_fd_25D/schematic
subckt current_mode_DB_fd_25D I\+ I\- IN\+ IN\- LO_0 LO_180 LO_270 LO_90 Q\+ Q\-
    M7 (IN\- LO_90 net17 0) nmos_rf lr=60n wr=sw_wn nr=1 m=sw_mul sigma=1
    M6 (IN\+ LO_270 net17 0) nmos_rf lr=60n wr=sw_wn nr=1 m=sw_mul sigma=1
    M5 (IN\- LO_270 net18 0) nmos_rf lr=60n wr=sw_wn nr=1 m=sw_mul sigma=1
    M4 (IN\+ LO_90 net18 0) nmos_rf lr=60n wr=sw_wn nr=1 m=sw_mul sigma=1
    M3 (IN\- LO_0 net13 0) nmos_rf lr=60n wr=sw_wn nr=1 m=sw_mul sigma=1
    M2 (IN\+ LO_180 net13 0) nmos_rf lr=60n wr=sw_wn nr=1 m=sw_mul sigma=1
    M1 (IN\- LO_180 net14 0) nmos_rf lr=60n wr=sw_wn nr=1 m=sw_mul sigma=1
    M0 (IN\+ LO_0 net14 0) nmos_rf lr=60n wr=sw_wn nr=1 m=sw_mul sigma=1
    I3 (net17 Q\-) transimpedance_amplifier_tsmc _par0=G _par1=res_w _par2=cap_w
    I2 (net18 Q\+) transimpedance_amplifier_tsmc _par0=G _par1=res_w _par2=cap_w
    I1 (net13 I\-) transimpedance_amplifier_tsmc _par0=G _par1=res_w _par2=cap_w
    I0 (net14 I\+) transimpedance_amplifier_tsmc _par0=G _par1=res_w _par2=cap_w
ends current_mode_DB_fd_25D

// Passive_mixer_ee20b087/Inverter/schematic
subckt Inverter VDD Vin Vout
parameters wn=1u muln=1 wp=2u mulp=1
    M0 (Vout Vin 0 0) nmos_rf lr=60n wr=wn nr=1 m=muln sigma=1
    M1 (Vout Vin VDD VDD) pmos_rf lr=60n wr=wp nr=1 m=mulp sigma=1
ends Inverter

// Passive_mixer_ee20b087/buffer_block/schematic
subckt buffer_block In Out Vdd
    I3 (Vdd w2 Out) Inverter wn=wn3 muln=mn3 wp=wp3 mulp=mp3
    I2 (Vdd w1 w2) Inverter wn=wn2 muln=mn2 wp=wp2 mulp=mp2
    I1 (Vdd w0 w1) Inverter wn=wn1 muln=mn1 wp=wp1 mulp=mp1
    I0 (Vdd In w0) Inverter wn=wn0 muln=mn0 wp=wp0 mulp=mp0
ends buffer_block

// Narasimhan/Mixer_DB_CM_25D_TB_tsmc/schematic
I0 (VO_IP VO_IN net016 net015 LO_0 LO_180 LO_270 LO_90 VO_QP VO_QN) current_mode_DB_fd_25D
PORT6 (net026 net025) port r=50 type=dc
PORT5 (net028 net027) port r=50 type=dc
PORT0 (net06 0) port r=50 type=dc pacmag=1
R6 (0 net010) resistor r=RN
R7 (net09 0) resistor r=RN
R5 (net05 0) resistor r=50
R4 (0 net051) resistor r=50
R3 (net16 0) resistor r=50
R2 (net10 0) resistor r=50
R1 (net17 0) resistor r=50
R0 (net11 0) resistor r=50
PORT4 (net16 0) port r=50 type=pulse delay=0.75*(1/flo) val0=0 val1=1.2 period=1/flo rise=0.001*(1/flo) fall=0.001*(1/flo) width=0.25*(1/flo) fundname="LO_270"
PORT2 (net17 0) port r=50 type=pulse delay=0.25*(1/flo) val0=0 val1=1.2 period=1/flo rise=0.001*(1/flo) fall=0.001*(1/flo) width=0.25*(1/flo) fundname="LO_90"
PORT3 (net10 0) port r=50 type=pulse delay=0.5*(1/flo) val0=0 val1=1.2 period=1/flo rise=0.001*(1/flo) fall=0.001*(1/flo) width=0.25*(1/flo) fundname="LO_180"
PORT1 (net11 0) port r=50 type=pulse delay=0 val0=0 val1=1.2 period=1/flo rise=0.001*(1/flo) fall=0.001*(1/flo) width=0.25*(1/flo) fundname="LO_0"
E7 (net025 0 VO_QN 0) vcvs gain=1.0
E4 (net028 0 VO_IP 0) vcvs gain=1.0
E5 (net027 0 VO_IN 0) vcvs gain=1.0
E6 (net026 0 VO_QP 0) vcvs gain=1.0
E0 (LO_0 0 net11 0) vcvs gain=1.0
E1 (LO_180 0 net10 0) vcvs gain=1.0
E3 (LO_270 0 net16 0) vcvs gain=1.0
E2 (LO_90 0 net17 0) vcvs gain=1.0
G1 (net09 0 net05 0) vccs gm=gm
G0 (net010 0 net051 0) vccs gm=gm
V2 (Vdd 0) vsource dc=Vdd type=dc
V1 (net09 net015) vsource dc=0 type=dc
V0 (net010 net016) vsource dc=0 type=dc
I1 (net06 net051 net05) balun rin=50 rout=50 loss=0
B3 (LO_270 LO_270 Vdd) buffer_block
B2 (LO_180 LO_180 Vdd) buffer_block
B1 (LO_90 LO_90 Vdd) buffer_block
B0 (LO_0 LO_0 Vdd) buffer_block
simulatorOptions options temp=temperature
// ANALYSIS STATEMENTS
sweeppss sweep param=flo start=flo_start stop=flo_stop lin=2 {
  pss_test pss fund=flo harms=50 errpreset=conservative restart=yes
+ annotate=status
// PAC STATEMENTS
  pac_test pac sweeptype=absolute start=flo+Bandwidth maxsideband=10
+ annotate=status
  pnoise_test ( VO_IP VO_IN ) pnoise sweeptype=absolute
+ start=1K stop=Bandwidth lin=100 maxsideband=10 iprobe=PORT0
+ refsideband=-1 noiseout=[usb] annotate=status
}

save V0:p
save V1:p
save V2:p
ahdl_include "/cad/tools/cadencetools/IC618/tools/dfII/samples/artist/rfLib/balun/veriloga/veriloga.va"
