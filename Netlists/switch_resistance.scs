// Design: Passive_mixer_ee20b087/switch_characterization_ON
simulator lang=spectre
global 0
// PARAMETERS
parameters f=550000000.0
parameters nfin=25
parameters mul=2
parameters Vsw=1.2
parameters min_fingers=10
parameters max_fingers=50
parameters temperature=27
include "/cad/library/TSMC/65/lp/tsmcN65/../models/spectre/toplevel.scs" section=tt_lib

// Passive_mixer_ee20b087/switch_characterization_ON/schematic
M0 (Vi net7 0 0) nmos_rf lr=60n wr=1u nr=nfin m=mul sigma=1
I1 (Vi 0) isource dc=0 type=dc mag=1
V0 (net7 0) vsource dc=Vsw type=dc
simulatorOptions options temp=temperature
// ANALYSIS STATEMENTS
ac_test ac freq=f param=nfin start=min_fingers stop=max_fingers step=1
// PRINT STATEMENTS
print mag(V(Vi)), name=ac_test to="ac.out"
