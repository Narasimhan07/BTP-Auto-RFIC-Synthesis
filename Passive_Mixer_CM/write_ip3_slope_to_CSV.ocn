openResults( "./psf" )
slope_ip3_curve = deriv(dbm(pvr("hb" "net027" "net028" 50 '(-1 2 -1))))
awvSaveToCSV(slope_ip3_curve "slope_ip3_curve.csv")
exit
